    .subckt BUFX4 vdd vss A Y
M0 vdd A a_2_6# vdd PMOS_VTH w=0.75u l=0.05u
+ ad=0p pd=0u as=0p ps=0u
M1 Y a_2_6# vdd vdd PMOS_VTH w=1u l=0.05u
+ ad=0p pd=0u as=0p ps=0u
M2 vdd a_2_6# Y vdd PMOS_VTH w=1u l=0.05u
+ ad=0p pd=0u as=0p ps=0u
M3 vss A a_2_6# vss NMOS_VTH w=1.5u l=0.05u
+ ad=0p pd=0u as=0p ps=0u
M4 Y a_2_6# vss vss NMOS_VTH w=0.5u l=0.05u
+ ad=0p pd=0u as=0p ps=0u
M5 vss a_2_6# Y vss NMOS_VTH w=0.5u l=0.05u
+ ad=0p pd=0u as=0p ps=0u

.ENDS
