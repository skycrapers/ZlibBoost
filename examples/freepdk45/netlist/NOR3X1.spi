    .subckt NOR3X1 vdd vss B C A Y
M0 vdd A a_2_64# vdd PMOS_VTH w=0.75u l=0.05u
+ ad=0p pd=0u as=0p ps=0u
M1 a_2_64# A vdd vdd PMOS_VTH w=0.75u l=0.05u
+ ad=0p pd=0u as=0p ps=0u
M2 a_25_64# B a_2_64# vdd PMOS_VTH w=0.75u l=0.05u
+ ad=0p pd=0u as=0p ps=0u
M3 a_2_64# B a_25_64# vdd PMOS_VTH w=0.75u l=0.05u
+ ad=0p pd=0u as=0p ps=0u
M4 Y C a_25_64# vdd PMOS_VTH w=0.75u l=0.05u
+ ad=0p pd=0u as=0p ps=0u
M5 a_25_64# C Y vdd PMOS_VTH w=0.75u l=0.05u
+ ad=0p pd=0u as=0p ps=0u
M6 Y A vss vss NMOS_VTH w=0.25u l=0.05u
+ ad=0p pd=0u as=0p ps=0u
M7 vss B Y vss NMOS_VTH w=0.25u l=0.05u
+ ad=0p pd=0u as=0p ps=0u
M8 Y C vss vss NMOS_VTH w=0.25u l=0.05u
+ ad=0p pd=0u as=0p ps=0u

.ENDS
