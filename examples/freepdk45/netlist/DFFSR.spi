    .subckt DFFSR vss vdd D S R Q CLK
M0 a_2_6# R vdd vdd PMOS_VTH w=0.5u l=0.05u
+ ad=0p pd=0u as=0p ps=0u
M1 vdd a_10_61# a_2_6# vdd PMOS_VTH w=0.5u l=0.05u
+ ad=0p pd=0u as=0p ps=0u
M2 a_10_61# a_23_27# vdd vdd PMOS_VTH w=0.5u l=0.05u
+ ad=0p pd=0u as=0p ps=0u
M3 vdd S a_10_61# vdd PMOS_VTH w=0.5u l=0.05u
+ ad=0p pd=0u as=0p ps=0u
M4 a_23_27# a_47_71# a_2_6# vdd PMOS_VTH w=0.25u l=0.05u
+ ad=0p pd=0u as=0p ps=0u
M5 a_57_6# a_47_4# a_23_27# vdd PMOS_VTH w=0.25u l=0.05u
+ ad=0p pd=0u as=0p ps=0u
M6 vdd D a_57_6# vdd PMOS_VTH w=0.5u l=0.05u
+ ad=0p pd=0u as=0p ps=0u
M7 vdd a_47_71# a_47_4# vdd PMOS_VTH w=0.5u l=0.05u
+ ad=0p pd=0u as=0p ps=0u
M8 a_47_71# CLK vdd vdd PMOS_VTH w=0.5u l=0.05u
+ ad=0p pd=0u as=0p ps=0u
M9 a_105_6# a_47_71# a_10_61# vdd PMOS_VTH w=0.25u l=0.05u
+ ad=0p pd=0u as=0p ps=0u
M10 a_113_6# a_47_4# a_105_6# vdd PMOS_VTH w=0.25u l=0.05u
+ ad=0p pd=0u as=0p ps=0u
M11 a_122_6# a_105_6# vdd vdd PMOS_VTH w=0.5u l=0.05u
+ ad=0p pd=0u as=0p ps=0u
M12 vdd R a_122_6# vdd PMOS_VTH w=0.5u l=0.05u
+ ad=0p pd=0u as=0p ps=0u
M13 a_113_6# a_122_6# vdd vdd PMOS_VTH w=0.5u l=0.05u
+ ad=0p pd=0u as=0p ps=0u
M14 vdd S a_113_6# vdd PMOS_VTH w=0.5u l=0.05u
+ ad=0p pd=0u as=0p ps=0u
M15 vdd a_122_6# Q vdd PMOS_VTH w=0.5u l=0.05u
+ ad=0p pd=0u as=0p ps=0u
M16 a_10_6# R a_2_6# vss NMOS_VTH w=0.5u l=0.05u
+ ad=0p pd=0u as=0p ps=0u
M17 vss a_10_61# a_10_6# vss NMOS_VTH w=0.5u l=0.05u
+ ad=0p pd=0u as=0p ps=0u
M18 a_26_6# a_23_27# vss vss NMOS_VTH w=0.5u l=0.05u
+ ad=0p pd=0u as=0p ps=0u
M19 a_10_61# S a_26_6# vss NMOS_VTH w=0.5u l=0.05u
+ ad=0p pd=0u as=0p ps=0u
M20 a_23_27# a_47_4# a_2_6# vss NMOS_VTH w=0.25u l=0.05u
+ ad=0p pd=0u as=0p ps=0u
M21 a_57_6# a_47_71# a_23_27# vss NMOS_VTH w=0.25u l=0.05u
+ ad=0p pd=0u as=0p ps=0u
M22 vss D a_57_6# vss NMOS_VTH w=0.25u l=0.05u
+ ad=0p pd=0u as=0p ps=0u
M23 vss a_47_71# a_47_4# vss NMOS_VTH w=0.25u l=0.05u
+ ad=0p pd=0u as=0p ps=0u
M24 a_47_71# CLK vss vss NMOS_VTH w=0.25u l=0.05u
+ ad=0p pd=0u as=0p ps=0u
M25 a_105_6# a_47_4# a_10_61# vss NMOS_VTH w=0.25u l=0.05u
+ ad=0p pd=0u as=0p ps=0u
M26 a_113_6# a_47_71# a_105_6# vss NMOS_VTH w=0.25u l=0.05u
+ ad=0p pd=0u as=0p ps=0u
M27 a_130_6# a_105_6# a_122_6# vss NMOS_VTH w=0.5u l=0.05u
+ ad=0p pd=0u as=0p ps=0u
M28 vss R a_130_6# vss NMOS_VTH w=0.5u l=0.05u
+ ad=0p pd=0u as=0p ps=0u
M29 a_146_6# a_122_6# vss vss NMOS_VTH w=0.5u l=0.05u
+ ad=0p pd=0u as=0p ps=0u
M30 a_113_6# S a_146_6# vss NMOS_VTH w=0.5u l=0.05u
+ ad=0p pd=0u as=0p ps=0u
M31 vss a_122_6# Q vss NMOS_VTH w=0.25u l=0.05u
+ ad=0p pd=0u as=0p ps=0u

.ENDS
